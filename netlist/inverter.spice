** sch_path: /home/eamtastudent/EAMTA2026-VLSI/design/blocks/inverter/inverter.sch
**.subckt inverter vdd vout vin vss
*.iopin vdd
*.iopin vout
*.iopin vss
*.iopin vin
XM1 vout vin vss vss sg13_lv_nmos w=0.75u l=0.15u ng=1
XM2 vout vin vdd vdd sg13_lv_pmos w=1.5u l=0.15u ng=1
**.ends
.end
