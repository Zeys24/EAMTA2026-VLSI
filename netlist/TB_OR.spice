** sch_path: /home/eamtastudent/EAMTA2026-VLSI/design/TB_OR.sch
**.subckt TB_OR
v1 avdd1p2 avss1p2 DC{vdd}
C1 vout avss1p2 10f
v2 avss1p2 0 DC{vss}
vA vA avss1p2 PULSE({vdd} 0 0.1n 1p 1p {Tclk/2} {Tclk}) DC 0 AC 0
vB vB avss1p2 PULSE({vdd} 0 0.1n 1p 1p {Tclk} {Tclk*2}) DC 0 AC 0
x2 avdd1p2 vA vB vout avss1p2 OR
**** begin user architecture code

* Circuit Parameters
.param vdd = 1.2
.param vss = 0.0
.param Tclk = 10n
.options TEMP = 27.0
* Include Models - IHP SG13G2
.lib cornerMOSlv.lib mos_tt
* OP Parameters & Singals to save
.save all
*Simulations
.control
tran 0.01u 100n
setplot tran1
plot v(vA) v(vB)+1.5 v(vout)+3
set filetype = ascii
write dcsweep.raw
.endc
.end

**** end user architecture code
**.ends

* expanding   symbol:  OR.sym # of pins=5
** sym_path: /home/eamtastudent/EAMTA2026-VLSI/design/OR.sym
** sch_path: /home/eamtastudent/EAMTA2026-VLSI/design/OR.sch
.subckt OR vdd vA vB vout vss
*.iopin vout
*.iopin vdd
*.iopin vss
*.iopin vA
*.iopin vB
XM1 vdd vB net2 vdd sg13_lv_nmos w=0.15u l=0.13u ng=1
XM2 vss vA net1 vss sg13_lv_pmos w=0.15u l=0.13u ng=1
XM3 net2 vA net1 vdd sg13_lv_nmos w=0.15u l=0.13u ng=1
XM4 vss vB net1 vss sg13_lv_pmos w=0.15u l=0.13u ng=1
x1 vdd vout net1 vss inverter-1.1
.ends

* expanding   symbol:  inverter-1.1.sym # of pins=4
** sym_path: /home/eamtastudent/EAMTA2026-VLSI/design/inverter-1.1.sym
** sch_path: /home/eamtastudent/EAMTA2026-VLSI/design/inverter-1.1.sch
.subckt inverter-1.1 vdd vout vin vss
*.iopin vdd
*.iopin vout
*.iopin vss
*.iopin vin
XM1 vout vin vss vss sg13_lv_nmos w=0.75u l=0.15u ng=1
XM2 vout vin vdd vdd sg13_lv_pmos w=1.5u l=0.15u ng=1
.ends

.end
