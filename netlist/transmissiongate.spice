** sch_path: /home/eamtastudent/EAMTA2026-VLSI/design/blocks/transmissiongate/transmissiongate.sch
**.subckt transmissiongate clk VSS vin vout VDD clk'
*.iopin vout
*.iopin vin
*.iopin clk
*.iopin clk'
*.iopin VSS
*.iopin VDD
XM1 vout clk' vin VDD sg13_lv_pmos w=1.5u l=0.15u ng=1
XM0 vout clk vin VSS sg13_lv_nmos w=0.75u l=0.15u ng=1
**.ends
.end
