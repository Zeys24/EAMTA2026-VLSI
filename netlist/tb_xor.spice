** sch_path: /home/eamtastudent/EAMTA2026-VLSI/verification/testbenches/tb_xor
**.subckt tb_xor
x1 vdd z b vss a Compuerta_xor
V1(a) a vss PULSE({vdd} 0 0.1n 1p 1p {Tclk/2} {Tclk}) DC 0 AC 0
V2(b) b vss PULSE({vdd} 0 0.15n 1p 1p {Tclk} {Tclk*2}) DC 0 AC 0
V3 vdd vss DC{vdd}
V4 vss 0 DC{vss}
C1 z vss 1f
**** begin user architecture code

* Circuit Parameters
.param vdd = 1.2
.param vss = 0.0
.param Tclk = 10n
.options TEMP = 27.0
* Include Models - IHP SG13G2
.lib cornerMOSlv.lib mos_tt
* OP Parameters & Singals to save
.save all
*Simulations
.control
tran 0.01u 100n
setplot tran1
plot v(a) v(b)+1.5 v(z)+3
set filetype = ascii
write dcsweep.raw
.endc
.end

**** end user architecture code
**.ends

* expanding   symbol:  blocks/xorgate/Compuerta_xor.sym # of pins=5
** sym_path: /home/eamtastudent/EAMTA2026-VLSI/design/blocks/xorgate/Compuerta_xor.sym
** sch_path: /home/eamtastudent/EAMTA2026-VLSI/design/blocks/xorgate/Compuerta_xor.sch
.subckt Compuerta_xor VDD Z B VSS A
*.iopin Z
*.iopin B
*.iopin VDD
*.iopin A
*.iopin VSS
XM1 net1 Ab VDD VDD sg13_lv_pmos w=1.5u l=0.15u ng=1
XM4 Z Ab net2 VSS sg13_lv_nmos w=1.5u l=0.15u ng=1
XM0 net1 Bb VDD VDD sg13_lv_pmos w=1.5u l=0.15u ng=1
XM3 Z B net1 VDD sg13_lv_pmos w=1.5u l=0.15u ng=1
XM2 Z A net1 VDD sg13_lv_pmos w=1.5u l=0.15u ng=1
XM8 Ab A VDD VDD sg13_lv_pmos w=1.5u l=0.15u ng=1
XM10 Bb B VDD VDD sg13_lv_pmos w=1.5u l=0.15u ng=1
XM5 Z A net3 VSS sg13_lv_nmos w=1.5u l=0.15u ng=1
XM9 Ab A VSS VSS sg13_lv_nmos w=0.75u l=0.15u ng=1
XM6 net2 Bb VSS VSS sg13_lv_nmos w=1.5u l=0.15u ng=1
XM11 Bb B VSS VSS sg13_lv_nmos w=0.75u l=0.15u ng=1
XM7 net3 B VSS VSS sg13_lv_nmos w=1.5u l=0.15u ng=1
.ends

.end
